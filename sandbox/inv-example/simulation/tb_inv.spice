** sch_path: /foss/designs/SAR-ASIC/sandbox/inv-example/tb_inv.sch
**.subckt tb_inv
V2 vdd_hi GND 5
V5 in GND dc 5 pulse 5 0 0 1n 1n 0.05u 0.1u
x1 vdd_hi in out GND inv
C1 out GND 10f
.save v(vdd_hi)
.save v(in)
.save v(out)
**** begin user architecture code
 ** manual skywater pdks install (with patches applied)
* .lib $::SKYWATER_MODELS/models/sky130.lib.spice tt

** opencircuitdesign pdks install
.lib /foss/pdks/sky130A/libs.tech/combined/sky130.lib.spice tt

.param mc_mm_switch=0
.param mc_pr_switch=0

.control
*set filetype=ascii
*save all

op
tran 0.1n 1u

write tb_inv.raw
*exit

.endc

**** end user architecture code
**.ends

* expanding   symbol:  inv.sym # of pins=4
** sym_path: /foss/designs/SAR-ASIC/sandbox/inv-example/inv.sym
** sch_path: /foss/designs/SAR-ASIC/sandbox/inv-example/inv.sch
.subckt inv VDD in out VSS
*.ipin in
*.opin out
*.ipin VDD
*.ipin VSS
XM10 out in VDD VDD sky130_fd_pr__pfet_g5v0d10v5 L=0.5 W=8 nf=2 ad=1.16 as=2.32 pd=8.58 ps=17.16 nrd=0.03625 nrs=0.03625 sa=0 sb=0
+ sd=0 mult=1
XM9 out in VSS VSS sky130_fd_pr__nfet_g5v0d10v5 L=0.5 W=2 nf=1 ad=0.58 as=0.58 pd=4.58 ps=4.58 nrd=0.145 nrs=0.145 sa=0 sb=0 sd=0
+ mult=1
.ends

.GLOBAL GND
.end
